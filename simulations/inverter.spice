** sch_path: /foss/designs/dsrt2026_AdemasFazriSunaryo/inverter.sch
**.subckt inverter
*  M1 -  nfet_01v8  IS MISSING !!!!
*  M2 -  pfet_01v8  IS MISSING !!!!
V1 in GND 0
V2 net1 GND 1.8
**** begin user architecture code
 .lib /foss/pdks/sky130A/libs.tech/ngspice/sky130.lib.spice tt

.option wnflag=0
.option savecurrents
.control
save all
dc v1 0 1.8 0.01
plot in out
op
.endc

**** end user architecture code
**.ends
.GLOBAL GND
.end
